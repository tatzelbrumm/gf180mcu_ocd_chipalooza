* slot_16 dummy: ports of verilog/rtl/slot16_wrapper.v, no devices
.subckt slot_16 vdd_5v0 vdd_3v3 vss_5v0 vss_3v3 enable clk reset dig_in[0] dig_in[1] dig_in[2] dig_in[3] dig_in[4] dig_in[5] dig_in[6] dig_in[7] dig_in[8] dig_in[9] dig_in[10] dig_in[11] dig_in[12] dig_in[13] dig_in[14] dig_in[15] dig_in[16] dig_in[17] dig_in[18] dig_in[19] dig_in[20] dig_in[21] dig_in[22] dig_in[23] dig_out[0] dig_out[1] dig_out[2] dig_out[3] dig_out[4] dig_out[5] dig_out[6] dig_out[7] dig_out[8] dig_out[9] dig_out[10] dig_out[11] s16_an_0_outp s16_an_0_outn s16_an_0_vcm s16_an_0_vref s16_an_0_iref s16_an_0_en_3v3 s16_an_0_en_3v3_b s16_an_1_vinp s16_an_1_vinn s16_an_1_vref s16_an_1_iref s16_an_1_en_3v3 s16_an_1_en_3v3_b ibias0 ibias1 vbias analog_bus0 analog_bus1 analog_bus2 analog_bus3
.ends
