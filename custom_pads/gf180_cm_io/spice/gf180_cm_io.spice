* gf180_cm_io: placeholder custom pads (copies of PDK digital pads, new core-side pins unconnected)
* needs $PDK_ROOT/$PDK/libs.ref/gf180mcu_ocd_io/spice/gf180mcu_ocd_io.spice

.subckt gf180_cm_io__asig_in DVDD DVSS VDD VSS pad outp outn vcm vref iref en_3v3 en_3v3_b
X0 DVDD DVSS pad nc_PD nc_PU VDD VSS nc_Y gf180mcu_ocd_io__in_c
* noconn outp outn vcm vref iref en_3v3 en_3v3_b
.ends

.subckt gf180_cm_io__asig_out DVDD DVSS VDD VSS pad vinp vinn vref iref en_3v3 en_3v3_b
X0 nc_A nc_CS DVDD DVSS nc_IE nc_OE pad nc_PD nc_PU nc_SL VDD VSS nc_Y gf180mcu_ocd_io__bi_24t
* noconn vinp vinn vref iref en_3v3 en_3v3_b
.ends
